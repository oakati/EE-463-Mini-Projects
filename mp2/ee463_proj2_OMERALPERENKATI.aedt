# Ansys Electronics Desktop project, version 2020.2
materials:
  vacuum: permittivity=1
  pec: conductivity=1e+30
  PMLGroup1_Z_1: permittivity{anisotropic component1=1.1229206 component2=1.1229206 component3=0.44526746} permeability{anisotropic component1=1.1229206 component2=1.1229206 component3=0.44526746} dielectric_loss_tangent{anisotropic component1=1 component2=1 component3=-1} magnetic_loss_tangent{anisotropic component1=1 component2=1 component3=-1}
  PMLGroup1_XZ_1: permittivity{anisotropic component1=1 component2=0.01 component3=1} permeability{anisotropic component1=1 component2=0.01 component3=1} dielectric_loss_tangent{anisotropic component1=0 component2=252.19013 component3=0} magnetic_loss_tangent{anisotropic component1=0 component2=252.19013 component3=0}
  PMLGroup1_YZ_1: permittivity{anisotropic component1=0.01 component2=1 component3=1} permeability{anisotropic component1=0.01 component2=1 component3=1} dielectric_loss_tangent{anisotropic component1=252.19013 component2=0 component3=0} magnetic_loss_tangent{anisotropic component1=252.19013 component2=0 component3=0}
  PMLGroup1_XYZ_1: permittivity{anisotropic component1=1.1229206 component2=1.1229206 component3=1.1229206} permeability{anisotropic component1=1.1229206 component2=1.1229206 component3=1.1229206} dielectric_loss_tangent{anisotropic component1=1 component2=1 component3=1} magnetic_loss_tangent{anisotropic component1=1 component2=1 component3=1}

design HFSSDesign1 (HFSS, DrivenModal, model units mm)
variables:
  dR = 0.094cm
  dL = 5.69cm
  gL = 0.094cm
geometry:
  Dipole [pec] = cylinder(axis=Z, base_centre=(0mm, 0mm, -dL/2), radius=dR, height=dL)
  gap [vacuum] = cylinder(axis=Z, base_centre=(0mm, 0mm, -gL/2), radius=dR, height=gL)
  gap_1 = gap.copy()
  Dipole.subtract(gap_1)
  gap_Section1 = gap.section(plane=YZ)
  RadiatingSurface [vacuum] = region(absolute_offset=31.25mm on all sides)
  coordinate_system FaceCS1 = face of RadiatingSurface: Origin=RadiatingSurface.vertex(1 of 8) FaceID=RadiatingSurface.face(+z) AxisPosn=RadiatingSurface.vertex(2 of 8) WhichAxis=X ZRotationAngle=0deg XOffset=0mm YOffset=0mm
  PML_RadiatingSurface_1 [PMLGroup1_Z_1, oriented by FaceCS1] = sweep_along_normal(RadiatingSurface.face(+z), length=49.774565mm)
  coordinate_system FaceCS2 = face of RadiatingSurface: Origin=RadiatingSurface.vertex(5 of 8) FaceID=RadiatingSurface.face(-z) AxisPosn=RadiatingSurface.vertex(6 of 8) WhichAxis=X ZRotationAngle=0deg XOffset=0mm YOffset=0mm
  PML_RadiatingSurface_2 [PMLGroup1_Z_1, oriented by FaceCS2] = sweep_along_normal(RadiatingSurface.face(-z), length=49.774565mm)
  coordinate_system FaceCS3 = face of RadiatingSurface: Origin=RadiatingSurface.vertex(4 of 8) FaceID=RadiatingSurface.face(-y) AxisPosn=RadiatingSurface.vertex(7 of 8) WhichAxis=X ZRotationAngle=0deg XOffset=0mm YOffset=0mm
  PML_RadiatingSurface_3 [PMLGroup1_Z_1, oriented by FaceCS3] = sweep_along_normal(RadiatingSurface.face(-y), length=49.774565mm)
  coordinate_system FaceCS4 = face of RadiatingSurface: Origin=RadiatingSurface.vertex(3 of 8) FaceID=RadiatingSurface.face(-x) AxisPosn=RadiatingSurface.vertex(8 of 8) WhichAxis=X ZRotationAngle=0deg XOffset=0mm YOffset=0mm
  PML_RadiatingSurface_4 [PMLGroup1_Z_1, oriented by FaceCS4] = sweep_along_normal(RadiatingSurface.face(-x), length=49.774565mm)
  coordinate_system FaceCS5 = face of RadiatingSurface: Origin=RadiatingSurface.vertex(2 of 8) FaceID=RadiatingSurface.face(+y) AxisPosn=RadiatingSurface.vertex(5 of 8) WhichAxis=X ZRotationAngle=0deg XOffset=0mm YOffset=0mm
  PML_RadiatingSurface_5 [PMLGroup1_Z_1, oriented by FaceCS5] = sweep_along_normal(RadiatingSurface.face(+y), length=49.774565mm)
  coordinate_system FaceCS6 = face of RadiatingSurface: Origin=RadiatingSurface.vertex(1 of 8) FaceID=RadiatingSurface.face(+x) AxisPosn=RadiatingSurface.vertex(6 of 8) WhichAxis=X ZRotationAngle=0deg XOffset=0mm YOffset=0mm
  PML_RadiatingSurface_6 [PMLGroup1_Z_1, oriented by FaceCS6] = sweep_along_normal(RadiatingSurface.face(+x), length=49.774565mm)
  PML_RadiatingSurface_7 [PMLGroup1_XZ_1, oriented by FaceCS3] = sweep_along_normal(PML_RadiatingSurface_1.face(at (0, -32.19, 84.5873)), length=49.774565mm)
  PML_RadiatingSurface_8 [PMLGroup1_XZ_1, oriented by FaceCS4] = sweep_along_normal(PML_RadiatingSurface_1.face(at (-32.19, 0, 84.5873)), length=49.774565mm)
  PML_RadiatingSurface_9 [PMLGroup1_XZ_1, oriented by FaceCS5] = sweep_along_normal(PML_RadiatingSurface_1.face(at (0, 32.19, 84.5873)), length=49.774565mm)
  PML_RadiatingSurface_10 [PMLGroup1_YZ_1, oriented by FaceCS1] = sweep_along_normal(PML_RadiatingSurface_1.face(at (32.19, 0, 84.5873)), length=49.774565mm)
  coordinate_system FaceCS7 = face of RadiatingSurface: Origin=RadiatingSurface.vertex(6 of 8) FaceID=RadiatingSurface.face(-z) AxisPosn=RadiatingSurface.vertex(7 of 8) WhichAxis=X ZRotationAngle=0deg XOffset=0mm YOffset=0mm
  PML_RadiatingSurface_11 [PMLGroup1_YZ_1, oriented by FaceCS7] = sweep_along_normal(PML_RadiatingSurface_2.face(at (0, -32.19, -84.5873)), length=49.774565mm)
  coordinate_system FaceCS8 = face of RadiatingSurface: Origin=RadiatingSurface.vertex(7 of 8) FaceID=RadiatingSurface.face(-z) AxisPosn=RadiatingSurface.vertex(8 of 8) WhichAxis=X ZRotationAngle=0deg XOffset=0mm YOffset=0mm
  PML_RadiatingSurface_12 [PMLGroup1_YZ_1, oriented by FaceCS8] = sweep_along_normal(PML_RadiatingSurface_2.face(at (-32.19, 0, -84.5873)), length=49.774565mm)
  PML_RadiatingSurface_13 [PMLGroup1_XZ_1, oriented by FaceCS2] = sweep_along_normal(PML_RadiatingSurface_2.face(at (0, 32.19, -84.5873)), length=49.774565mm)
  PML_RadiatingSurface_14 [PMLGroup1_YZ_1, oriented by FaceCS2] = sweep_along_normal(PML_RadiatingSurface_2.face(at (32.19, 0, -84.5873)), length=49.774565mm)
  PML_RadiatingSurface_15 [PMLGroup1_YZ_1, oriented by FaceCS3] = sweep_along_normal(PML_RadiatingSurface_3.face(at (-32.19, -57.0773, 0)), length=49.774565mm)
  PML_RadiatingSurface_16 [PMLGroup1_YZ_1, oriented by FaceCS6] = sweep_along_normal(PML_RadiatingSurface_3.face(at (32.19, -57.0773, 0)), length=49.774565mm)
  PML_RadiatingSurface_17 [PMLGroup1_YZ_1, oriented by FaceCS4] = sweep_along_normal(PML_RadiatingSurface_4.face(at (-57.0773, 32.19, 0)), length=49.774565mm)
  PML_RadiatingSurface_18 [PMLGroup1_YZ_1, oriented by FaceCS5] = sweep_along_normal(PML_RadiatingSurface_5.face(at (32.19, 57.0773, 0)), length=49.774565mm)
  PML_RadiatingSurface_19 [PMLGroup1_XYZ_1, oriented by FaceCS3] = sweep_along_normal(PML_RadiatingSurface_7.face(at (-32.19, -57.0773, 84.5873)), length=49.774565mm)
  PML_RadiatingSurface_20 [PMLGroup1_XYZ_1, oriented by FaceCS1] = sweep_along_normal(PML_RadiatingSurface_7.face(at (32.19, -57.0773, 84.5873)), length=49.774565mm)
  PML_RadiatingSurface_21 [PMLGroup1_XYZ_1, oriented by FaceCS4] = sweep_along_normal(PML_RadiatingSurface_8.face(at (-57.0773, 32.19, 84.5873)), length=49.774565mm)
  PML_RadiatingSurface_22 [PMLGroup1_XYZ_1, oriented by FaceCS5] = sweep_along_normal(PML_RadiatingSurface_9.face(at (32.19, 57.0773, 84.5873)), length=49.774565mm)
  PML_RadiatingSurface_23 [PMLGroup1_XYZ_1, oriented by FaceCS8] = sweep_along_normal(PML_RadiatingSurface_11.face(at (-32.19, -57.0773, -84.5873)), length=49.774565mm)
  PML_RadiatingSurface_24 [PMLGroup1_XYZ_1, oriented by FaceCS7] = sweep_along_normal(PML_RadiatingSurface_11.face(at (32.19, -57.0773, -84.5873)), length=49.774565mm)
  coordinate_system FaceCS9 = face of RadiatingSurface: Origin=RadiatingSurface.vertex(8 of 8) FaceID=RadiatingSurface.face(-z) AxisPosn=RadiatingSurface.vertex(5 of 8) WhichAxis=X ZRotationAngle=0deg XOffset=0mm YOffset=0mm
  PML_RadiatingSurface_25 [PMLGroup1_XYZ_1, oriented by FaceCS9] = sweep_along_normal(PML_RadiatingSurface_12.face(at (-57.0773, 32.19, -84.5873)), length=49.774565mm)
  PML_RadiatingSurface_26 [PMLGroup1_XYZ_1, oriented by FaceCS2] = sweep_along_normal(PML_RadiatingSurface_13.face(at (32.19, 57.0773, -84.5873)), length=49.774565mm)
boundaries and excitations:
  PML_radiation1: Radiation Faces=RadiatingSurface.face(+z) IsForPML
  PML_radiation2: Radiation Faces=RadiatingSurface.face(-z) IsForPML
  PML_radiation3: Radiation Faces=RadiatingSurface.face(-y) IsForPML
  PML_radiation4: Radiation Faces=RadiatingSurface.face(-x) IsForPML
  PML_radiation5: Radiation Faces=RadiatingSurface.face(+y) IsForPML
  PML_radiation6: Radiation Faces=RadiatingSurface.face(+x) IsForPML
  1: Lumped Port Objects=gap_Section1 Modes{Mode1{IntLine{middle of gap_Section1.edge(at (0, 0, -0.47)) -> middle of gap_Section1.edge(at (0, 0, 0.47))} CharImp=Zpi RenormImp=72.8114ohm}} Impedance=50ohm
setups:
  2_4GHz: HfssDriven Frequency=2.4GHz MaxDeltaS=0.01 MaximumPasses=15 MinimumPasses=2 MinimumConvergedPasses=2 PercentRefinement=30 BasisOrder=1 PortAccuracy=2
    sweep 1_2GHz__3_6GHz: 1.2GHz to 3.6GHz, 481 points; Type=Interpolating InterpTolerance=0.5 InterpMaxSolns=250 InterpUsePortImped=false PassivityErrorTolerance=0.0001
source amplitudes:
  1:1: 1W 0deg
optimetrics:
  ParametricSetup1: Parametric Sim._Setups=[2_4GHz]
    sweep dL: 5.52cm 5.72cm 5.59cm
  dL_5_59cm: Parametric Sim._Setups=[2_4GHz]
    sweep dL: 5.59cm
  dL_5_67cm: Parametric Sim._Setups=[2_4GHz]
    sweep dL: 5.67cm
  dL_5_69cm: Parametric Sim._Setups=[2_4GHz]
    sweep dL: 5.69cm
  dR: Parametric Sim._Setups=[2_4GHz]
    sweep dR: LINC 0.047cm 0.141cm 5
radiation setups:
  3D: Infinite Sphere Theta=0deg..180deg step 1deg Phi=-180deg..180deg step 1deg
  Elevation: Infinite Sphere Theta=-180deg..180deg step 1deg Phi=0deg..90deg step 90deg
  Azimuth: Infinite Sphere Theta=90deg..90deg step 0deg Phi=-180deg..180deg step 1deg
  P_Plane: Infinite Sphere Theta=-180deg..180deg step 1deg Phi=0deg..0deg step 0deg
reports:
  Sparams_dL: dB(S(1,1)), dB(S(1,1)), dB(S(1,1)), dB(S(1,1)), dB(S(1,1)), dB(S(1,1)) vs Freq
  Cutplane Gain: dB(GainTotal), dB(GainTotal) vs Theta
  3D Directivity: dB(DirTotal) vs Phi, Theta on 2_4GHz : LastAdaptive, 3D [Freq=2.4GHz]
  Z matrix: re(Z(1,1)), re(Z(1,1)), re(Z(1,1)), re(Z(1,1)), re(Z(1,1)), im(Z(1,1)), im(Z(1,1)), im(Z(1,1)), im(Z(1,1)), im(Z(1,1)), im(Z(1,1)) vs Freq
  Sparams_dR: dB(S(1,1)), dB(S(1,1)), dB(S(1,1)), dB(S(1,1)), dB(S(1,1)) vs Freq
  Active Z Parameter Chart 1: Z(1,1) vs Freq
  Z Parameter Plot 1: re(Z(1,1)), re(Z(1,1)), re(Z(1,1)), re(Z(1,1)), re(Z(1,1)), im(Z(1,1)), im(Z(1,1)), im(Z(1,1)), im(Z(1,1)), im(Z(1,1)) vs Freq
  Gain Plot 1: GainTotal vs Phi, Theta on 2_4GHz : LastAdaptive, 3D [Freq=2.4GHz]
  S Parameter Chart 2: S(1,1), S(1,1), S(1,1), S(1,1), S(1,1) vs Freq
